## /*********************************************************************
##  * SYNOPSYS CONFIDENTIAL                                             *
##  *                                                                   *
##  * This is an unpublished, proprietary work of Synopsys, Inc., and   *
##  * is fully protected under copyright and trade secret laws. You may *
##  * not view, use, disclose, copy, or distribute this file or any     *
##  * information contained herein except pursuant to a valid written   *
##  * license from Synopsys.                                            *
## **********************************************************************/

# This file contains the DUT register and memory definitions

#
# Lab 7 - Task 6
# Populate each of the following register and memory specification.
#
register HOST_ID {
#  ToDo
  field REV_ID {
    bits 8;
    access ro;
    reset 'h03;
  }
  field CHIP_ID {
    bits 8;
    access ro;
    reset 'h5A;
  }
}

register PORT_LOCK {
#  ToDo
  field LOCK {
    bits 16;
    access w1c;
    reset 'hffff;
  }
}

register HOST_REG {
#  ToDo
  field USER_REG {
    bits 16;
    access rw;
    reset 'h0;
  }
}

memory RAM {
#  ToDo
  size 4k;
  bits 16;
  access rw;
}

virtual register vreg_rw {
       bytes 2;
       field f1 { bits 16; access rw; };
}
virtual register vreg_ro {
       bytes 2;
       field f1 { bits 8; access rw; };
       field f2 { bits 8; access ro; };
}
virtual register vreg_w1c {
       bytes 2;
       field f1 { bits 8; access rw; };
       field f2 { bits 8; access w1c; };
}

#
# The block level declaration is done for you.  This include the hdl_path name for
# the signals in the DUT.  Later on, the hdl_path will be in RAL backdoor access.
#
block host_regmodel {
  bytes 2;
  register HOST_ID       (host_id)       @'h0000;
  register PORT_LOCK     (lock)          @'h0100;
  register HOST_REG[256] (host_reg[%d])  @'h1000; # array must specify HDL index
  memory   RAM           (ram)           @'h4000;
  virtual register vreg_ro=vreg_ro[3]    RAM @0x100;
  virtual register vreg_rw=vreg_rw[20]   RAM @0x0;
  virtual register vreg_w1c=vreg_w1c[5]   RAM @0x200;
}


## block dut {
##    bytes 2;
##    memory ram1 (vreg) @0x0000
##    virtual register vreg_rw=vreg_rw[20] ram1 @0x0;
##    virtual register vreg_ro=vreg_ro[3] ram1 @0x100;
##    virtual register vreg_w1c=vreg_w1c[5] ram1 @0x200;
## }

