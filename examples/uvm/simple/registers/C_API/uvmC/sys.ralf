#-------------------------------------------------------------
#    Copyright 2011 Synopsys, Inc.
#    All Rights Reserved Worldwide
#
# SYNOPSYS CONFIDENTIAL - This is an unpublished, proprietary work of
# Synopsys, Inc., and is fully protected under copyright and trade
# secret laws. You may not view, use, disclose, copy, or distribute this
# file or any information contained herein except pursuant to a valid
# written license from Synopsys.
#
#-------------------------------------------------------------

block comp1 {
   bytes 4;

   register regA @ 0x00 {
      field data { bits 32; }
   }

   register regB @ 0x04 {
      field fldA { bits 8; }
      field fldB { bits 8; }
      field fldC { bits 16; }
   }
   register regC @ 0x08 {
      field data { bits 32; }
   }
}


block comp2 {
   bytes 4;

   register regA @ 0x00 {
      field data { bits 32; }
   }

   regfile rf1[4] @ 0x100+0x10 {
      register r0 @ 0x0 {
         field data { bits 32; }
       }
      register r1 @ 0x04 {
         field fA { bits 16; }
         field fB { bits 16; }
      }
      register r2 @ 0x08 {
         field data { bits 32; }
      }
   }

   register regE @ 0x1F0 {
      field data { bits 32; }
   }
}


system sys {
   bytes 4;

   block comp1=Comp1a @ 0x1a0000;
   block comp1=Comp1b @ 0x1b0000;
   block comp2=Comp2  @ 0x200000;
}
